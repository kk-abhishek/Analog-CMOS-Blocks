*** SPICE deck for cell CS_amp_ac{sch} from library 5zCS_amp1
*** Created on Fri Jun 19, 2026 08:29:58
*** Last revised on Mon Jul 20, 2026 17:56:45
*** Written on Mon Jul 20, 2026 18:10:53 by Electric VLSI Design System,
*version 9.03
*** Layout tech: mocmos, foundry MOSIS
*** UC SPICE *** , MIN_RESIST 4.0, MIN_CAPAC 0.1FF

.global gnd

*** TOP LEVEL CELL: 5zCS_amp1:CS_amp_ac{sch}
Mnmos-4@0 Vout Vb Vss Vss nmos L=0.4U W=2U
Mpmos-4@0 vdd Vin Vout vdd pmos L=0.4U W=10U
VACVoltag@0 Vin gnd DC=1V AC=2V SIN (1V 2V 1,000 1ns)

* Spice Code nodes in cell cell '5zCS_amp1:CS_amp_ac{sch}'
VDD Vdd 0 DC 2.5
VSS Vss 0 DC -2.5
Vbias Vbias 0 Dc 2.5
.ac dec 20 100 500000meg
.include "C:\130micron.txt"
.END
