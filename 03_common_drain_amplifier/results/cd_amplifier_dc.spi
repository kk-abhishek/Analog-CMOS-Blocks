*** SPICE deck for cell cd_amplifier_dc{sch} from library 3zcd_amplifier1
*** Created on Sun Jul 05, 2026 16:15:05
*** Last revised on Sun Jul 19, 2026 19:22:16
*** Written on Mon Jul 20, 2026 18:23:39 by Electric VLSI Design System,
*version 9.03
*** Layout tech: mocmos, foundry MOSIS
*** UC SPICE *** , MIN_RESIST 4.0, MIN_CAPAC 0.1FF

*** SUBCIRCUIT cd_amplifier_sch FROM CELL cd_amplifier_sch{sch}
.SUBCKT cd_amplifier_sch Vbias Vdd Vin Vout Vss
Mnmos-4@0 Vdd Vin Vout Vss nmos L=0.4U W=10U
Mnmos-4@1 Vout Vbias Vss Vss nmos L=0.4U W=2U
.ENDS cd_amplifier_sch

*** TOP LEVEL CELL: cd_amplifier_dc{sch}
Xcd_ampli@0 Vbias Vdd Vin Vout Vss cd_amplifier_sch

* Spice Code nodes in cell cell 'cd_amplifier_dc{sch}'
VDD Vdd 0 DC 2.5
VSS Vss 0 DC -2.5
Vbias Vbias 0 Dc 0.5
VIN Vin 0 SIN(1 0.4 1k 0 0 0)
*.dc Vin -5 5 1m
.tran 0 5m
.include "C:\130micron.txt"
.END
