*** SPICE deck for cell ac_diff_amp{sch} from library 7zdiff_amp1
*** Created on Sun Jul 05, 2026 12:34:26
*** Last revised on Sun Jul 19, 2026 19:33:15
*** Written on Mon Jul 20, 2026 19:03:26 by Electric VLSI Design System,
*version 9.03
*** Layout tech: mocmos, foundry MOSIS
*** UC SPICE *** , MIN_RESIST 4.0, MIN_CAPAC 0.1FF

*** SUBCIRCUIT Diff_amplifier FROM CELL Diff_amplifier{sch}
.SUBCKT Diff_amplifier IDC V1 V2 Vout Vss vdd
Mnmos-4@4 net@129 V1 net@86 Vss nmos L=2U W=0.6U
Mnmos-4@5 Vout V2 net@86 Vss nmos L=2U W=0.6U
Mnmos-4@6 IDC IDC Vss Vss nmos L=2U W=0.9U
Mnmos-4@7 net@86 IDC Vss Vss nmos L=2U W=0.9U
Mpmos-4@4 net@129 net@129 vdd vdd pmos L=2U W=3U
Mpmos-4@5 Vout net@129 vdd vdd pmos L=2U W=3U
.ENDS Diff_amplifier

.global gnd

*** TOP LEVEL CELL: ac_diff_amp{sch}
VACVoltag@0 V1 gnd DC=1V AC=2V SIN (1V 2V 1,000 1ns)
IDCCurren@0 vdd IDC DC 30uA
XDiff_amp@0 IDC V1 gnd Vout Vss vdd Diff_amplifier

* Spice Code nodes in cell cell 'ac_diff_amp{sch}'
VDD Vdd 0 DC 2.5
VSS Vss 0 DC -2.5
.ac dec 20 100 5g
.include "C:\130micron.txt"
.END
