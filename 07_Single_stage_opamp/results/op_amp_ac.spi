*** SPICE deck for cell op_amp_ac{sch} from library 1op_amp
*** Created on Fri Jun 19, 2026 16:36:05
*** Last revised on Mon Jul 20, 2026 19:27:50
*** Written on Mon Jul 20, 2026 19:28:27 by Electric VLSI Design System,
*version 9.03
*** Layout tech: mocmos, foundry MOSIS
*** UC SPICE *** , MIN_RESIST 4.0, MIN_CAPAC 0.1FF

*** SUBCIRCUIT op_cs_amp FROM CELL op_cs_amp{sch}
.SUBCKT op_cs_amp Vbias Vin Vout Vss vdd
Mnmos-4@0 Vout Vbias Vss Vss nmos L=0.4U W=2U
Mpmos-4@0 vdd Vin Vout vdd pmos L=0.4U W=10U
.ENDS op_cs_amp

*** SUBCIRCUIT op_diff_amp FROM CELL op_diff_amp{sch}
.SUBCKT op_diff_amp IDC V1 V2 Vout Vss vdd
Mnmos-4@0 net@11 V1 net@38 Vss nmos L=2U W=0.6U
Mnmos-4@1 Vout V2 net@38 Vss nmos L=2U W=0.6U
Mnmos-4@2 IDC IDC Vss Vss nmos L=2U W=0.9U
Mnmos-4@3 net@38 IDC Vss Vss nmos L=2U W=0.9U
Mpmos-4@0 net@11 net@11 vdd vdd pmos L=2U W=3U
Mpmos-4@1 Vout net@11 vdd vdd pmos L=2U W=3U
.ENDS op_diff_amp

*** SUBCIRCUIT op_amp_sch FROM CELL op_amp_sch{sch}
.SUBCKT op_amp_sch IDC V1 V2 Vout Vss vdd
Xcs_amp@0 net@77 IDC Vout Vss vdd op_cs_amp
Xdiff_amp@0 IDC V1 V2 net@77 Vss vdd op_diff_amp
.ENDS op_amp_sch

.global gnd

*** TOP LEVEL CELL: op_amp_ac{sch}
VACVoltag@0 V1 gnd DC=0v AC=2V SIN (0v 2V 1,000 1ns)
IDCCurren@0 vdd IDC DC 30uA
Xop_amp_s@0 IDC V1 gnd Vout Vss vdd op_amp_sch

* Spice Code nodes in cell cell 'op_amp_ac{sch}'
Vdd Vdd 0 dc 2.5
Vss Vss 0 DC -2.5
.ac dec 20 100 5g
.include "C:\130micron.txt"
.END
