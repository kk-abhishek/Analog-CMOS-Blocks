*** SPICE deck for cell zCurrent_mirror1_ac{sch} from library
*6zCurrent_mirror1
*** Created on Sat Dec 15, 2018 13:49:26
*** Last revised on Mon Jul 20, 2026 19:14:51
*** Written on Mon Jul 20, 2026 19:15:31 by Electric VLSI Design System,
*version 9.03
*** Layout tech: mocmos, foundry MOSIS
*** UC SPICE *** , MIN_RESIST 4.0, MIN_CAPAC 0.1FF

*** TOP LEVEL CELL: zCurrent_mirror1_ac{sch}
Mnmos-4@0 vout net@32 vss vss nmos L=0.4U W=2U
Mpmos-4@0 vout net@0 vdd vdd pmos L=0.4U W=10U
Mpmos-4@1 net@0 net@0 vdd vdd pmos L=0.4U W=10U
VACVoltag@0 net@32 vss DC=1V AC=2V SIN (1V 2V 1,000 1ns)
IDCCurren@0 net@0 vss DC 100u

* Spice Code nodes in cell cell 'zCurrent_mirror1_ac{sch}'
VDD Vdd 0 DC 2.5
VSS Vss 0 DC -2.5
.ac dec 20 100 100g
.include "C:\130micron.txt"
.END
