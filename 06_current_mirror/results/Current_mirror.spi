*** SPICE deck for cell Current_mirror{sch} from library 6zCurrent_mirror1
*** Created on Sun Jul 05, 2026 13:20:01
*** Last revised on Mon Jul 20, 2026 19:11:05
*** Written on Mon Jul 20, 2026 19:12:13 by Electric VLSI Design System,
*version 9.03
*** Layout tech: mocmos, foundry MOSIS
*** UC SPICE *** , MIN_RESIST 4.0, MIN_CAPAC 0.1FF

*** TOP LEVEL CELL: Current_mirror{sch}
Mnmos-4@3 Vout vin Vss Vss nmos L=0.4U W=2U
Mpmos-4@1 Vout net@10 vdd vdd pmos L=0.4U W=10U
Mpmos-4@2 net@10 net@10 vdd vdd pmos L=0.4U W=10U
IDCCurren@1 net@10 Vss DC 100u

* Spice Code nodes in cell cell 'Current_mirror{sch}'
VDD Vdd 0 DC 2.5
VSS Vss 0 DC -2.5
VIN vin 0 SIN(-2.0045 20m 1k 0 0 0)
*VIN1 V2 0 DC 0
.dc Vin -2.5 20 1m
*.tran 0 15m
.include "C:\130micron.txt"
.END
